* PESD36VL1BL - engineering approximation for Altium MixedSim / PSpice
* Bidirectional 36 V TVS/ESD diode
* Nexperia datasheet targets: VRWM 36 V, VBR typ 41 V @ 10 mA,
* VCL typ 42 V @ 1 A (8/20 us), VCL typ 52 V @ 16 A (100 ns), C typ 10.5 pF.
*
* Pin 1 = terminal 1
* Pin 2 = terminal 2

.MODEL PESD36CORE D(IS=1e-12 N=1.05 RS=0.55 BV=40.5 IBV=10m TT=0.1n)

.SUBCKT PESD36VL1BL 1 2
D1 1 3 PESD36CORE
D2 2 3 PESD36CORE
C1 1 2 10.5p
.ENDS PESD36VL1BL
