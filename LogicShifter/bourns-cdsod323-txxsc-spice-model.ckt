****
* Bourns Inc Pspice model for CDSOD323-TxxS and CDSOD323-TxxSC Series Version 1.0
* March 2015
* All rights reserved
*
*   This Spice model models the nominal behaviour of the CDSOD323-TxxS and CDSOD323-TxxSC Series within the
* limitations of Pspice standard models.
*
*   While the model strives to match actual device performance, not all aspects
* of the performance of this model may correspond to actual device behaviour due
* to Pspice limitations
*
*   Simulations using this model should not be used to prove validity of circuit design
* or any aspects of performance, due to inherent inaccuracies of Pspice models.
*
*   All simulations should be checked and correlated with actual bench measurements
* of typical devices.
*
*   This model may be updated or changed without notice.
****

********** CDSOD323-T03S **********

* Typ. Breakdown Voltage = 5.6V
* Typ. Cap. Unidirectional @ 0 V, 1 MHz = 496pF

.SUBCKT CDSOD323-T03S 1 2
DTVS1 2 3 DTVS
DID1 2 3 DID
L1 3 1 0.8n
.MODEL DTVS D(BV=5.6 IBV=0.001 RS=0.15 VJ=0.378 CJO=496p M=0.245 N=2 IS=1.3E-08)
.MODEL DID D(RS=0.62)
.ENDS

********** CDSOD323-T05S **********

* Typ. Breakdown Voltage = 7.5V
* Typ. Cap. Unidirectional @ 0 V, 1 MHz = 328pF

.SUBCKT CDSOD323-T05S 1 2
DTVS1 2 3 DTVS
DID1 2 3 DID
L1 3 1 0.8n
.MODEL DTVS D(BV=7.5 IBV=0.001 RS=0.19 VJ=0.388 CJO=328p M=0.28 N=1.54 IS=4.4E-12)
.MODEL DID D(RS=0.49)
.ENDS

********** CDSOD323-T08S **********

* Typ. Breakdown Voltage = 10.9V
* Typ. Cap. Unidirectional @ 0 V, 1 MHz = 223pF

.SUBCKT CDSOD323-T08S 1 2
DTVS1 2 3 DTVS
DID1 2 3 DID
L1 3 1 0.8n
.MODEL DTVS D(BV=10.9 IBV=0.001 RS=0.21 VJ=0.384 CJO=223p M=0.296 N=1.43 IS=4.7E-13)
.MODEL DID D(RS=0.52)
.ENDS

********** CDSOD323-T12S **********

* Typ. Breakdown Voltage = 14.7V
* Typ. Cap. Unidirectional @ 0 V, 1 MHz = 143pF

.SUBCKT CDSOD323-T12S 1 2
DTVS1 2 3 DTVS
DID1 2 3 DID
L1 3 1 0.8n
.MODEL DTVS D(BV=14.7 IBV=0.001 RS=0.32 VJ=0.446 CJO=143p M=0.309 N=1.39 IS=2.7E-13)
.MODEL DID D(RS=0.1)
.ENDS

********** CDSOD323-T15S **********

* Typ. Breakdown Voltage = 19.0V
* Typ. Cap. Unidirectional @ 0 V, 1 MHz = 106pF

.SUBCKT CDSOD323-T15S 1 2
DTVS1 2 3 DTVS
DID1 2 3 DID
L1 3 1 0.8n
.MODEL DTVS D(BV=19 IBV=0.001 RS=0.39 VJ=0.495 CJO=106p M=0.331 N=1.39 IS=2.2E-13)
.MODEL DID D(RS=0.08)
.ENDS

********** CDSOD323-T18S **********

* Typ. Breakdown Voltage = 22.1V
* Typ. Cap. Unidirectional @ 0 V, 1 MHz = 90pF

.SUBCKT CDSOD323-T18S 1 2
DTVS1 2 3 DTVS
DID1 2 3 DID
L1 3 1 0.8n
.MODEL DTVS D(BV=22.1 IBV=0.001 RS=0.51 VJ=0.528 CJO=90p M=0.340 N=1.39 IS=2.2E-13)
.MODEL DID D(RS=0.08)
.ENDS

********** CDSOD323-T24S **********

* Typ. Breakdown Voltage = 30.5V
* Typ. Cap. Unidirectional @ 0 V, 1 MHz = 77pF

.SUBCKT CDSOD323-T24S 1 2
DTVS1 2 3 DTVS
DID1 2 3 DID
L1 3 1 0.8n
.MODEL DTVS D(BV=30.5 IBV=0.001 RS=0.87 VJ=0.592 CJO=77p M=0.362 N=1.38 IS=2.4E-13)
.MODEL DID D(RS=0.08)
.ENDS

********** CDSOD323-T36S **********

* Typ. Breakdown Voltage = 41.0V
* Typ. Cap. Unidirectional @ 0 V, 1 MHz = 63pF

.SUBCKT CDSOD323-T36S 1 2
DTVS1 2 3 DTVS
DID1 2 3 DID
L1 3 1 0.8n
.MODEL DTVS D(BV=41 IBV=0.001 RS=2.07 VJ=0.696 CJO=63p M=0.376 N=1.3 IS=1.2E-13)
.MODEL DID D(RS=0.09)
.ENDS

********** CDSOD323-T03SC **********

* Typ. Breakdown Voltage = 5.6V
* Typ. Cap. Bidirectional @ 0 V, 1 MHz = 248pF

.SUBCKT CDSOD323-T03SC 1 2
DTVS1 3 1 DTVS
DID1 3 1 DID
DTVS2 4 2 DTVS
DID2 4 2 DID
L1 3 4 0.8n
.MODEL DTVS D(BV=5.6 IBV=0.001 RS=0.15 VJ=0.378 CJO=496p M=0.245 N=2 IS=1.3E-08)
.MODEL DID D(RS=0.62)
.ENDS

********** CDSOD323-T05SC **********

* Typ. Breakdown Voltage = 7.5V
* Typ. Cap. Bidirectional @ 0 V, 1 MHz = 164pF

.SUBCKT CDSOD323-T05SC 1 2
DTVS1 3 1 DTVS
DID1 3 1 DID
DTVS2 4 2 DTVS
DID2 4 2 DID
L1 3 4 0.8n
.MODEL DTVS D(BV=7.5 IBV=0.001 RS=0.19 VJ=0.388 CJO=328p M=0.28 N=1.54 IS=4.4E-12)
.MODEL DID D(RS=0.49)
.ENDS

********** CDSOD323-T08SC **********

* Typ. Breakdown Voltage = 10.9V
* Typ. Cap. Bidirectional @ 0 V, 1 MHz = 111.5pF

.SUBCKT CDSOD323-T08SC 1 2
DTVS1 3 1 DTVS
DID1 3 1 DID
DTVS2 4 2 DTVS
DID2 4 2 DID
L1 3 4 0.8n
.MODEL DTVS D(BV=10.9 IBV=0.001 RS=0.21 VJ=0.384 CJO=223p M=0.296 N=1.43 IS=4.7E-13)
.MODEL DID D(RS=0.52)
.ENDS

********** CDSOD323-T12SC **********

* Typ. Breakdown Voltage = 14.7V
* Typ. Cap. Bidirectional @ 0 V, 1 MHz = 71.5pF

.SUBCKT CDSOD323-T12SC 1 2
DTVS1 3 1 DTVS
DID1 3 1 DID
DTVS2 4 2 DTVS
DID2 4 2 DID
L1 3 4 0.8n
.MODEL DTVS D(BV=14.7 IBV=0.001 RS=0.32 VJ=0.446 CJO=143p M=0.309 N=1.39 IS=2.7E-13)
.MODEL DID D(RS=0.1)
.ENDS

********** CDSOD323-T15SC **********

* Typ. Breakdown Voltage = 19V
* Typ. Cap. Bidirectional @ 0 V, 1 MHz = 53pF

.SUBCKT CDSOD323-T15SC 1 2
DTVS1 3 1 DTVS
DID1 3 1 DID
DTVS2 4 2 DTVS
DID2 4 2 DID
L1 3 4 0.8n
.MODEL DTVS D(BV=19 IBV=0.001 RS=0.39 VJ=0.495 CJO=106p M=0.331 N=1.39 IS=2.2E-13)
.MODEL DID D(RS=0.08)
.ENDS

********** CDSOD323-T18SC **********

* Typ. Breakdown Voltage = 22.1V
* Typ. Cap. Bidirectional @ 0 V, 1 MHz = 45pF

.SUBCKT CDSOD323-T18SC 1 2
DTVS1 3 1 DTVS
DID1 3 1 DID
DTVS2 4 2 DTVS
DID2 4 2 DID
L1 3 4 0.8n
.MODEL DTVS D(BV=22.1 IBV=0.001 RS=0.51 VJ=0.528 CJO=90p M=0.340 N=1.39 IS=2.2E-13)
.MODEL DID D(RS=0.08)
.ENDS

********** CDSOD323-T24SC **********

* Typ. Breakdown Voltage = 30.5V
* Typ. Cap. Bidirectional @ 0 V, 1 MHz = 38.5pF

.SUBCKT CDSOD323-T24SC 1 2
DTVS1 3 1 DTVS
DID1 3 1 DID
DTVS2 4 2 DTVS
DID2 4 2 DID
L1 3 4 0.8n
.MODEL DTVS D(BV=30.5 IBV=0.001 RS=0.87 VJ=0.592 CJO=77p M=0.362 N=1.38 IS=2.4E-13)
.MODEL DID D(RS=0.08)
.ENDS

********** CDSOD323-T36SC **********

* Typ. Breakdown Voltage = 41.0V
* Typ. Cap. Bidirectional @ 0 V, 1 MHz = 31.5pF

.SUBCKT CDSOD323-T36SC 1 2
DTVS1 3 1 DTVS
DID1 3 1 DID
DTVS2 4 2 DTVS
DID2 4 2 DID
L1 3 4 0.8n
.MODEL DTVS D(BV=41 IBV=0.001 RS=2.07 VJ=0.696 CJO=63p M=0.376 N=1.3 IS=1.2E-13)
.MODEL DID D(RS=0.09)
.ENDS
